# Ansys Electronics Desktop project, version 2023.2
materials:
  vacuum: permittivity=1
  copper: permeability=0.999991 conductivity=58000000
  FR4_epoxy: permittivity=4.4 dielectric_loss_tangent=0.02
  air: permittivity=1.0006 permeability=1.0000004

design HFSSDesign1 (HFSS, HFSS Terminal Network, model units mm)
geometry:
  Box1 [FR4_epoxy] = box(corner=(140mm, 105mm, -1.7mm), size=(-70mm, -65mm, 1.5mm))
  Cylinder1 = cylinder(axis=Z, base_centre=(108.913mm, 75.68400154mm, 0mm), radius=0.29999813mm, height=-4.5mm)
  Cylinder2 = cylinder(axis=Z, base_centre=(90.55499796mm, 75.68800204mm, 0mm), radius=0.29320633mm, height=-2.1mm)
  Box1.subtract(Cylinder1, Cylinder2)
  Box2 [air] = box(corner=(170mm, 10mm, -100mm), size=(-130mm, 130mm, 200mm))
  LP1 = polyline(z=0.1mm, xy in mm: (86.868, 75.542001) (90.291194, 75.5420003) (90.336193, 72.833999) (86.91299864, 72.83399962), closed, covered)
  Copper [copper] = imported_body()
boundaries and excitations:
  Rad1: Radiation Objects=Box2
  1: Lumped Port Faces=LP1.face LumpedPortType=Modal Modes{Mode1{IntLine{(88.624596, 72.83399962, 0.1) -> (88.579597, 75.5420003, 0.1)} CharImp=Zpi}} Impedance=50ohm
setups:
  Setup1: HfssDrivenAuto AutoSolverSetting=Balanced Type=Interpolating
    sweep Sweep: 10MHz to 30MHz step 10kHz;
source amplitudes:
  1:1: 1V 0deg
reports:
  Z Parameter Plot 1: normalize(Z(1,1)), im(Z(1,1)) vs Freq on Setup1 : Sweep; markers m1 at 13.56MHz
  S Parameter Chart 1: S(1,1) on Setup1 : Sweep [Freq=all]; markers m1 at 13.56MHz
