# Ansys Electronics Desktop project, version 2023.2
materials:
  vacuum: permittivity=1
  FR4_epoxy: permittivity=4.4 dielectric_loss_tangent=0.02
  copper: permeability=0.999991 conductivity=58000000
  air: permittivity=1.0006 permeability=1.0000004

design HFSSDesign1 (HFSS, HFSS Terminal Network, model units mm)
geometry:
  Box1 [FR4_epoxy] = box(corner=(140mm, 50mm, -0.1mm), size=(-75mm, 65mm, -1.5mm))
  Cylinder1 = cylinder(axis=Z, base_centre=(103.402mm, 83.23600066mm, 0.1mm), radius=0.29999813mm, height=-2mm)
  Cylinder2 = cylinder(axis=Z, base_centre=(120.787mm, 83.23600066mm, 0.1mm), radius=0.3011068mm, height=-2mm)
  Box1.subtract(Cylinder1, Cylinder2)
  Box2 [air] = box(corner=(180mm, 10mm, -150mm), size=(-160mm, 150mm, 300mm))
  LP1 = polyline(z=0.1mm, xy in mm: (125.787, 81.88599828) (122.057, 81.88599828) (122.057, 83.08600096) (125.787, 83.08600096), closed, covered)
  Copper [copper] = imported_body()
boundaries and excitations:
  Rad1: Radiation Objects=Box2
  1: Lumped Port Faces=LP1.face LumpedPortType=Modal Modes{Mode1{IntLine{(123.922, 83.08600096, 0.1) -> (123.922, 81.88599828, 0.1)} CharImp=Zpi}} Impedance=50ohm
setups:
  Setup1: HfssDrivenAuto AutoSolverSetting=Balanced Type=Interpolating
    sweep Sweep: 10MHz to 30MHz step 10kHz;
source amplitudes:
  1:1: 1V 0deg
reports:
  Z Parameter Plot 1: re(Z(1,1)), im(Z(1,1)) vs Freq on Setup1 : Sweep; markers m1 at 13.56MHz
