# Ansys Electronics Desktop project, version 2023.2
materials:
  vacuum: permittivity=1
  FR4_epoxy: permittivity=4.4 dielectric_loss_tangent=0.02
  copper: permeability=0.999991 conductivity=58000000
  air: permittivity=1.0006 permeability=1.0000004
  PVC plastic: permittivity=2.7 dielectric_loss_tangent=0.007
  marble: permittivity=8.3

design HFSSDesign1 (HFSS, HFSS Modal Network, model units mm)
geometry:
  Box1 [FR4_epoxy] = box(corner=(71mm, 87mm, -0.2mm), size=(31mm, -29mm, -1.5mm))
  Cylinder1 = cylinder(axis=Z, base_centre=(79.60300056mm, 72.53300073mm, 0mm), radius=0.40159903mm, height=-3mm)
  Cylinder2 = cylinder(axis=Z, base_centre=(74.803mm, 72.517mm, 0mm), radius=0.40159813mm, height=-3mm)
  Box1.subtract(Cylinder1)
  Box1.subtract(Cylinder2)
  Box2 [air] = box(corner=(130mm, 40mm, -100mm), size=(-80mm, 70mm, 200mm))
  LP1 = polyline(z=0.1mm, xy in mm: (71.501, 72.39) (74.53121, 72.39) (74.53121, 70.485) (71.501, 70.485), closed, covered)
  Copper [copper] = imported_body()
  Box3 [PVC plastic] = box(corner=(71mm, 58mm, -2.2mm), size=(31mm, 29mm, -10mm))
  Box4 [marble] = box(corner=(102mm, 58mm, -13mm), size=(-31mm, 29mm, -29.8mm))
boundaries and excitations:
  Rad1: Radiation Objects=Box2
  1: Lumped Port Faces=LP1.face LumpedPortType=Modal Modes{Mode1{IntLine{(73.016105, 72.39, 0.1) -> (73.016105, 70.485, 0.1)} CharImp=Zpi}} Impedance=50ohm
setups:
  Setup1: HfssDrivenAuto AutoSolverSetting=Balanced Type=Interpolating
    sweep Sweep: 5MHz to 30MHz step 10kHz;
source amplitudes:
  1:1: 1V 0deg
reports:
  S Parameter Chart 1: S(1,1) on Setup1 : Sweep [Freq=all]; markers m1 at 13.56MHz
  Z Parameter Plot 1: re(Z(1,1)), im(Z(1,1)) vs Freq on Setup1 : Sweep; markers m1 at 13.56MHz
