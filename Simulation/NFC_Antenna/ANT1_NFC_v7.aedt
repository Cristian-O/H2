# Ansys Electronics Desktop project, version 2023.2
materials:
  vacuum: permittivity=1
  FR4_epoxy: permittivity=4.4 dielectric_loss_tangent=0.02
  copper: permeability=0.999991 conductivity=58000000
  air: permittivity=1.0006 permeability=1.0000004

design HFSSDesign1 (HFSS, HFSS Modal Network, model units mm)
geometry:
  Box1 [FR4_epoxy] = box(corner=(75mm, 45mm, -0.1mm), size=(75mm, 70mm, -1.5mm))
  Cylinder1 = cylinder(axis=Z, base_centre=(114.798mm, 77.87500046mm, 0mm), radius=0.29999813mm, height=-2.3mm)
  Cylinder2 = cylinder(axis=Z, base_centre=(96.68299942mm, 77.87500046mm, 0mm), radius=0.29999813mm, height=-4mm)
  Box1.subtract(Cylinder1, Cylinder2)
  Box2 [air] = box(corner=(220mm, -20mm, -150mm), size=(-220mm, 200mm, 300mm))
  LP1 = polyline(z=0.1mm, xy in mm: (91.68299926, 79.2250003) (95.41299942, 79.2250003) (95.41299942, 78.02500016) (91.68299926, 78.02500016), closed, covered)
  Copper [copper] = imported_body()
boundaries and excitations:
  Rad1: Radiation Objects=Box2
  1: Lumped Port Faces=LP1.face LumpedPortType=Modal Modes{Mode1{IntLine{(93.54799934, 78.02500016, 0.1) -> (93.54799934, 79.2250003, 0.1)} CharImp=Zpi}} Impedance=50ohm
setups:
  Setup1: HfssDrivenAuto AutoSolverSetting=Balanced Type=Interpolating
    sweep Sweep: 10MHz to 30MHz step 10kHz;
source amplitudes:
  1:1: 1V 0deg
reports:
  Z Parameter Plot 1: re(Z(1,1)), im(Z(1,1)) vs Freq on Setup1 : Sweep; markers m1 at 13.56MHz
