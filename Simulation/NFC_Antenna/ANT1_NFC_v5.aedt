# Ansys Electronics Desktop project, version 2023.2
materials:
  vacuum: permittivity=1
  FR4_epoxy: permittivity=4.4 dielectric_loss_tangent=0.02
  copper: permeability=0.999991 conductivity=58000000
  air: permittivity=1.0006 permeability=1.0000004

design HFSSDesign1 (HFSS, HFSS Terminal Network, model units mm)
geometry:
  Box1 [FR4_epoxy] = box(corner=(165mm, 35mm, -0.1mm), size=(-65mm, 65mm, -1.5mm))
  Cylinder1 = cylinder(axis=Z, base_centre=(131.834001mm, 68.49000018mm, 0mm), radius=0.29999813mm, height=-3.8mm)
  Cylinder2 = cylinder(axis=Z, base_centre=(113.3339999mm, 68.48999764mm, 0mm), radius=0.30000067mm, height=-2.35mm)
  Box1.subtract(Cylinder1, Cylinder2)
  Box2 [air] = box(corner=(220mm, 0mm, -150mm), size=(-180mm, 170mm, 300mm))
  LP1 = polyline(z=0.1mm, xy in mm: (109.834, 68.340001) (113.07419, 68.34000048) (113.07419, 65.639998) (109.834, 65.63999826), closed, covered)
  Bottom_Layer_1 [copper] = imported_body()
boundaries and excitations:
  Rad1: Radiation Objects=Box2
  1: Lumped Port Faces=LP1.face LumpedPortType=Modal Modes{Mode1{IntLine{(111.4541, 68.34000048, 0.1) -> (111.4541, 65.63999826, 0.1)} CharImp=Zpi}} Impedance=50ohm
setups:
  Setup1: HfssDrivenAuto AutoSolverSetting=Balanced Type=Interpolating
    sweep Sweep: 10MHz to 30MHz step 10kHz;
source amplitudes:
  1:1: 1V 0deg
reports:
  Z Parameter Plot 1: re(Z(1,1)), im(Z(1,1)) vs Freq on Setup1 : Sweep; markers m1 at 13.56MHz
