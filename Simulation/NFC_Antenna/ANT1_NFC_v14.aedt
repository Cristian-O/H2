# Ansys Electronics Desktop project, version 2023.2
materials:
  vacuum: permittivity=1
  copper: permeability=0.999991 conductivity=58000000
  FR4_epoxy: permittivity=4.4 dielectric_loss_tangent=0.02
  air: permittivity=1.0006 permeability=1.0000004

design HFSSDesign1 (HFSS, HFSS Terminal Network, model units mm)
geometry:
  Cylinder1 = cylinder(axis=Z, base_centre=(102.143mm, 74.97799838mm, 0mm), radius=0.30171584mm, height=-2mm)
  Cylinder2 = cylinder(axis=Z, base_centre=(84.1429991mm, 73.97800038mm, 0mm), radius=0.29999813mm, height=-2.4mm)
  Box1 [FR4_epoxy] = box(corner=(130mm, 45mm, -0.1mm), size=(-65mm, 60mm, -1.5mm))
  Box1.subtract(Cylinder1, Cylinder2)
  Box2 [air] = box(corner=(40mm, 20mm, -150mm), size=(120mm, 110mm, 300mm))
  LP1 = polyline(z=0.1mm, xy in mm: (82.69299946, 74.67799898) (79.39300098, 74.67799898) (79.39300098, 75.32800022) (82.69299946, 75.32800022), closed, covered)
  Copper [copper] = imported_body()
boundaries and excitations:
  Rad1: Radiation Objects=Box2
  1: Lumped Port Faces=LP1.face LumpedPortType=Modal Modes{Mode1{IntLine{(81.04300022, 75.32800022, 0.1) -> (81.04300022, 74.67799898, 0.1)} CharImp=Zpi}} Impedance=50ohm
setups:
  Setup1: HfssDrivenAuto AutoSolverSetting=Balanced Type=Interpolating
    sweep Sweep: 10MHz to 30MHz step 10kHz;
source amplitudes:
  1:1: 1V 0deg
reports:
  Z Parameter Plot 1: re(Z(1,1)), im(Z(1,1)) vs Freq on Setup1 : Sweep; markers m1 at 13.56MHz
