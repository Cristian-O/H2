# Ansys Electronics Desktop project, version 2023.2
materials:
  vacuum: permittivity=1
  FR4_epoxy: permittivity=4.4 dielectric_loss_tangent=0.02
  copper: permeability=0.999991 conductivity=58000000
  air: permittivity=1.0006 permeability=1.0000004

design HFSSDesign1 (HFSS, HFSS Terminal Network, model units mm)
geometry:
  Box1 [FR4_epoxy] = box(corner=(140mm, 35mm, -0.05mm), size=(-65mm, 55mm, -1.5mm))
  Cylinder1 = cylinder(axis=Z, base_centre=(94.742mm, 65.151mm, 0mm), radius=0.29999813mm, height=-2.5mm)
  Cylinder2 = cylinder(axis=Z, base_centre=(111.505mm, 65.15599872mm, 0mm), radius=0.40045171mm, height=-2.5mm)
  Box1.subtract(Cylinder1, Cylinder2)
  Box2 [air] = box(corner=(180mm, 0mm, -100mm), size=(-140mm, 140mm, 200mm))
  LP1 = polyline(z=0.1mm, xy in mm: (94.482194, 65.3009997) (91.059, 65.300999) (91.059, 67.4140003) (94.482194, 67.414001), closed, covered)
  Copper [copper] = imported_body()
boundaries and excitations:
  Rad1: Radiation Objects=Box2
  1: Lumped Port Faces=LP1.face LumpedPortType=Modal Modes{Mode1{IntLine{(92.770597, 67.4140003, 0.1) -> (92.770597, 65.3009997, 0.1)} CharImp=Zpi}} Impedance=50ohm
setups:
  Setup1: HfssDrivenAuto AutoSolverSetting=Balanced Type=Interpolating
    sweep Sweep: 10MHz to 30MHz step 10kHz;
source amplitudes:
  1:1: 1V 0deg
reports:
  Z Parameter Plot 2: re(Z(1,1)), im(Z(1,1)) vs Freq on Setup1 : Sweep; markers m1 at 13.56MHz
  S Parameter Chart 1: S(1,1) on Setup1 : Sweep [Freq=all]; markers m1 at 13.56MHz
