# Ansys Electronics Desktop project, version 2023.2
materials:
  vacuum: permittivity=1
  air: permittivity=1.0006 permeability=1.0000004
  FR4_epoxy: permittivity=4.4 dielectric_loss_tangent=0.02
  copper: permeability=0.999991 conductivity=58000000

design HFSSDesign1 (HFSS, HFSS Terminal Network, model units mm)
geometry:
  Box1 [FR4_epoxy] = box(corner=(116mm, 56mm, -0.1mm), size=(-60mm, 54mm, -1.54mm))
  Cylinder1 = cylinder(axis=Z, base_centre=(103.21mm, 81.93400174mm, 0mm), radius=0.28784628mm, height=-2.7mm)
  Cylinder2 = cylinder(axis=Z, base_centre=(85.3750007mm, 81.93400174mm, 0mm), radius=0.29999813mm, height=-2.6mm)
  Box1.subtract(Cylinder1, Cylinder2)
  Box2 [air] = box(corner=(150mm, 25mm, -150mm), size=(-130mm, 125mm, 300mm))
  Copper [copper] = imported_body()
  LP1 = polyline(z=0.1mm, xy in mm: (110.66, 80.85900008) (107.36, 80.85900008) (107.36, 81.50900132) (110.66, 81.50900132), closed, covered)
boundaries and excitations:
  Rad1: Radiation Objects=Box2
  1: Lumped Port Faces=LP1.face LumpedPortType=Modal Modes{Mode1{IntLine{(109.01, 81.50900132, 0.1) -> (109.01, 80.85900008, 0.1)} CharImp=Zpi}} Impedance=50ohm
setups:
  Setup1: HfssDrivenAuto AutoSolverSetting=Balanced Type=Interpolating
    sweep Sweep: 10MHz to 30MHz step 10kHz;
source amplitudes:
  1:1: 1V 0deg
reports:
  Z Parameter Plot 1: re(Z(1,1)), im(Z(1,1)) vs Freq on Setup1 : Sweep; markers m1 at 13.56MHz
