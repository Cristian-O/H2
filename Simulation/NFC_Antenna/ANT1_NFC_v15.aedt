# Ansys Electronics Desktop project, version 2023.2
materials:
  vacuum: permittivity=1
  FR4_epoxy: permittivity=4.4 dielectric_loss_tangent=0.02
  air: permittivity=1.0006 permeability=1.0000004
  copper: permeability=0.999991 conductivity=58000000

design HFSSDesign1 (HFSS, HFSS Terminal Network, model units mm)
geometry:
  Cylinder1 = cylinder(axis=Z, base_centre=(107.04mm, 81.4190015mm, 0mm), radius=0.29999813mm, height=-2.1mm)
  Cylinder2 = cylinder(axis=Z, base_centre=(91.03999826mm, 81.4190015mm, 0mm), radius=0.29999813mm, height=-2.2mm)
  Box1 [FR4_epoxy] = box(corner=(140mm, 50mm, -0.1mm), size=(-70mm, 65mm, -1.5mm))
  Box1.subtract(Cylinder1, Cylinder2)
  Box2 [air] = box(corner=(40mm, 20mm, -150mm), size=(140mm, 140mm, 300mm))
  LP1 = polyline(z=0.1mm, xy in mm: (86.29000014, 82.76900134) (89.58999862, 82.76900134) (89.58999862, 82.1190001) (86.29000014, 82.1190001), closed, covered)
  copper [copper] = imported_body()
boundaries and excitations:
  Rad1: Radiation Objects=Box2
  1: Lumped Port Faces=LP1.face LumpedPortType=Modal Modes{Mode1{IntLine{(87.93999938, 82.1190001, 0.1) -> (87.93999938, 82.76900134, 0.1)} CharImp=Zpi}} Impedance=50ohm
setups:
  Setup1: HfssDrivenAuto AutoSolverSetting=Balanced Type=Interpolating
    sweep Sweep: 10MHz to 30MHz step 10kHz;
source amplitudes:
  1:1: 1V 0deg
reports:
  Z Parameter Plot 1: re(Z(1,1)), im(Z(1,1)) vs Freq on Setup1 : Sweep; markers m1 at 13.56MHz
