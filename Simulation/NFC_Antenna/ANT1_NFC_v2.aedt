# Ansys Electronics Desktop project, version 2023.2
materials:
  vacuum: permittivity=1
  copper: permeability=0.999991 conductivity=58000000
  FR4_epoxy: permittivity=4.4 dielectric_loss_tangent=0.02
  air: permittivity=1.0006 permeability=1.0000004

design HFSSDesign1 (HFSS, HFSS Terminal Network, model units mm)
geometry:
  Box1 [FR4_epoxy] = box(corner=(102mm, 58mm, -0.02mm), size=(-32mm, 32mm, -1.5mm))
  Cylinder1 = cylinder(axis=Z, base_centre=(79.60300056mm, 72.53299946mm, 0mm), radius=0.40159813mm, height=-3mm)
  Cylinder2 = cylinder(axis=Z, base_centre=(73.67599946mm, 72.53299946mm, 0mm), radius=0.402448mm, height=-3mm)
  Box1.subtract(Cylinder1, Cylinder2)
  Box2 [air] = box(corner=(118mm, 34mm, -100mm), size=(-72mm, 86mm, 200mm))
  Bottom_Layer_1 [copper] = imported_body()
  LP1 = polyline(z=0.1mm, xy in mm: (71.374, 72.383) (73.416194, 72.38299976) (73.448675, 71.413001) (71.40648152, 71.4130017), closed, covered)
boundaries and excitations:
  Rad1: Radiation Objects=Box2
  1: Lumped Port Faces=LP1.face LumpedPortType=Modal Modes{Mode1{IntLine{(72.427578, 71.4130017, 0.1) -> (72.395097, 72.38299976, 0.1)} CharImp=Zpi}} Impedance=50ohm
setups:
  Setup1: HfssDrivenAuto AutoSolverSetting=Balanced Type=Interpolating
    sweep Sweep: 5MHz to 30MHz step 10kHz;
source amplitudes:
  1:1: 1V 0deg
reports:
  Z Parameter Plot 1: re(Z(1,1)), im(Z(1,1)) vs Freq on Setup1 : Sweep; markers m1 at 13.56MHz
