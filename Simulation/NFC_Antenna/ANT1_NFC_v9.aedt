# Ansys Electronics Desktop project, version 2023.2
materials:
  vacuum: permittivity=1
  Isola FR408: permittivity=3.66 dielectric_loss_tangent=0.012
  FR4_epoxy: permittivity=4.4 dielectric_loss_tangent=0.02
  copper: permeability=0.999991 conductivity=58000000
  air: permittivity=1.0006 permeability=1.0000004

design HFSSDesign1 (HFSS, HFSS Terminal Network, model units mm)
geometry:
  Box1 [FR4_epoxy] = box(corner=(155mm, 40mm, -0.1mm), size=(-85mm, 85mm, -1.5mm))
  Cylinder1 = cylinder(axis=Z, base_centre=(115.296mm, 78.21499978mm, 0mm), radius=0.30073432mm, height=-7mm)
  Cylinder2 = cylinder(axis=Z, base_centre=(114.1310011mm, 98.96499892mm, 0mm), radius=0.30097458mm, height=-2.6mm)
  Box1.subtract(Cylinder1, Cylinder2)
  Box2 [air] = box(corner=(30mm, 0mm, -150mm), size=(160mm, 170mm, 300mm))
  copper [copper] = imported_body()
  LP1 = polyline(z=0.1mm, xy in mm: (114.756, 101.0149999) (114.756, 104.315) (115.406, 104.315) (115.406, 101.0149999), closed, covered)
boundaries and excitations:
  Rad1: Radiation Objects=Box2
  1: Lumped Port Faces=LP1.face LumpedPortType=Modal Modes{Mode1{IntLine{(115.406, 102.665, 0.1) -> (114.756, 102.665, 0.1)} CharImp=Zpi}} Impedance=50ohm
setups:
  Setup1: HfssDrivenAuto AutoSolverSetting=Balanced Type=Interpolating
    sweep Sweep: 10MHz to 30MHz step 10kHz;
source amplitudes:
  1:1: 1V 0deg
reports:
  Z Parameter Plot 1: re(Z(1,1)), im(Z(1,1)) vs Freq on Setup1 : Sweep; markers m1 at 13.56MHz
