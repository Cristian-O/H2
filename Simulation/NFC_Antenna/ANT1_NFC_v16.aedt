# Ansys Electronics Desktop project, version 2023.2
materials:
  vacuum: permittivity=1
  FR4_epoxy: permittivity=4.4 dielectric_loss_tangent=0.02
  copper: permeability=0.999991 conductivity=58000000
  air: permittivity=1.0006 permeability=1.0000004
  PVC plastic: permittivity=2.7 dielectric_loss_tangent=0.007
  marble: permittivity=8.3

design HFSSDesign1 (HFSS, HFSS Terminal Network, model units mm)
geometry:
  Cylinder1 = cylinder(axis=Z, base_centre=(97.07099966mm, 83.5050019mm, 0mm), radius=0.29999813mm, height=-2.2mm)
  Cylinder2 = cylinder(axis=Z, base_centre=(79.0710001mm, 83.5050019mm, 0mm), radius=0.29999813mm, height=-2.2mm)
  Box1 [FR4_epoxy] = box(corner=(60mm, 50mm, -0.1mm), size=(80mm, 80mm, -1.5mm))
  Box1.subtract(Cylinder1, Cylinder2)
  Copper [copper] = imported_body()
  Box2 [air] = box(corner=(0mm, 180mm, -150mm), size=(200mm, -180mm, 300mm))
  LP1 = polyline(z=0.1mm, xy in mm: (74.32100198, 84.85500174) (77.62100046, 84.85500174) (77.62100046, 84.2050005) (74.32100198, 84.2050005), closed, covered)
  PVC [PVC plastic, non-model] = box(corner=(60mm, 130mm, -1.85mm), size=(80mm, -80mm, -10mm))
  Marble [marble, non-model] = box(corner=(60mm, 130mm, -12mm), size=(80mm, -80mm, -25mm))
boundaries and excitations:
  Rad1: Radiation Objects=Box2
  1: Lumped Port Faces=LP1.face LumpedPortType=Modal Modes{Mode1{IntLine{(75.97100122, 84.2050005, 0.1) -> (75.97100122, 84.85500174, 0.1)} CharImp=Zpi}} Impedance=50ohm
setups:
  Setup1: HfssDrivenAuto AutoSolverSetting=Balanced Type=Interpolating
    sweep Sweep: 10MHz to 30MHz step 10kHz;
source amplitudes:
  1:1: 1V 0deg
reports:
  Z Parameter Plot 1: re(Z(1,1)), im(Z(1,1)) vs Freq on Setup1 : Sweep; markers m1 at 13.56MHz
