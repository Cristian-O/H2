# Ansys Electronics Desktop project, version 2023.2
materials:
  vacuum: permittivity=1
  FR4_epoxy: permittivity=4.4 dielectric_loss_tangent=0.02
  copper: permeability=0.999991 conductivity=58000000
  air: permittivity=1.0006 permeability=1.0000004

design HFSSDesign1 (HFSS, HFSS Modal Network, model units mm)
geometry:
  Cylinder1 = cylinder(axis=Z, base_centre=(91.13999806mm, 66.27200106mm, 0mm), radius=0.29999813mm, height=-3mm)
  Cylinder2 = cylinder(axis=Z, base_centre=(74.13999904mm, 66.27200106mm, 0mm), radius=0.30030531mm, height=-3mm)
  Box1 [FR4_epoxy] = box(corner=(125mm, 100mm, -0.1mm), size=(-70mm, -65mm, -1.5mm))
  Box1.subtract(Cylinder1, Cylinder2)
  Box2 [air] = box(corner=(25mm, 5mm, -150mm), size=(145mm, 125mm, 300mm))
  LP1 = polyline(z=0.1mm, xy in mm: (68.63999988, 68.1219999) (73.6399975, 68.1219999) (73.6399975, 66.42200076) (68.63999988, 66.42200076), closed, covered)
  Copper [copper] = imported_body()
boundaries and excitations:
  Rad1: Radiation Objects=Box2
  1: Lumped Port Faces=LP1.face LumpedPortType=Modal Modes{Mode1{IntLine{(71.13999869, 66.42200076, 0.1) -> (71.13999869, 68.1219999, 0.1)} CharImp=Zpi}} Impedance=50ohm
setups:
  Setup1: HfssDrivenAuto AutoSolverSetting=Balanced Type=Interpolating
    sweep Sweep: 10MHz to 30MHz step 10kHz;
source amplitudes:
  1:1: 1V 0deg
reports:
  Z Parameter Plot 1: re(Z(1,1)), im(Z(1,1)) vs Freq on Setup1 : Sweep; markers m1 at 13.56MHz
  S Parameter Chart 1: S(1,1) on Setup1 : Sweep [Freq=all]
