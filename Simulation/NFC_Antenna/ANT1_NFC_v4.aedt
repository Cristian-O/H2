# Ansys Electronics Desktop project, version 2023.2
materials:
  vacuum: permittivity=1
  FR4_epoxy: permittivity=4.4 dielectric_loss_tangent=0.02
  copper: permeability=0.999991 conductivity=58000000
  air: permittivity=1.0006 permeability=1.0000004
  PVC plastic: permittivity=2.7 dielectric_loss_tangent=0.007
  iron: permeability=4000 conductivity=10300000
  marble: permittivity=8.3

design HFSSDesign1 (HFSS, HFSS Terminal Network, model units mm)
geometry:
  Box1 [FR4_epoxy] = box(corner=(185mm, 105mm, -0.1mm), size=(-70mm, -65mm, -1.5mm))
  Cylinder1 = cylinder(axis=Z, base_centre=(152.7080004mm, 73.49600236mm, 0mm), radius=0.30737635mm, height=-6.8mm)
  Cylinder2 = cylinder(axis=Z, base_centre=(134.874mm, 73.533mm, 0mm), radius=0.29999813mm, height=-6.3mm)
  Box1.subtract(Cylinder1, Cylinder2)
  Box2 [air] = box(corner=(80mm, 140mm, -100mm), size=(140mm, -130mm, 200mm))
  LP1 = polyline(z=0.1mm, xy in mm: (131.191, 73.383001) (134.61419, 73.3830003) (134.63119, 72.145999) (131.208, 72.14599998), closed, covered)
  Copper [copper] = imported_body()
  Box3 [PVC plastic] = box(corner=(115mm, 40mm, -1.9mm), size=(70mm, 65mm, -10mm))
  Box4 [marble] = box(corner=(185mm, 40mm, -12.1mm), size=(-70mm, 65mm, -30mm))
boundaries and excitations:
  Rad1: Radiation Objects=Box2
  1: Lumped Port Faces=LP1.face LumpedPortType=Modal Modes{Mode1{IntLine{(132.9196, 72.14599998, 0.1) -> (132.9026, 73.3830003, 0.1)} CharImp=Zpi}} Impedance=50ohm
setups:
  Setup1: HfssDrivenAuto AutoSolverSetting=Balanced Type=Interpolating
    sweep Sweep: 10MHz to 30MHz step 10kHz;
source amplitudes:
  1:1: 1V 0deg
reports:
  Z Parameter Plot 1: re(Z(1,1)), im(Z(1,1)) vs Freq on Setup1 : Sweep; markers m1 at 13.56MHz
  S Parameter Chart 1: S(1,1) on Setup1 : Sweep [Freq=all]; markers m1 at 13.56MHz
