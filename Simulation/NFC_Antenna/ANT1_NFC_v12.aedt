# Ansys Electronics Desktop project, version 2023.2
materials:
  vacuum: permittivity=1
  copper: permeability=0.999991 conductivity=58000000
  FR4_epoxy: permittivity=4.4 dielectric_loss_tangent=0.02
  air: permittivity=1.0006 permeability=1.0000004

design HFSSDesign1 (HFSS, HFSS Terminal Network, model units mm)
geometry:
  Cylinder1 = cylinder(axis=Z, base_centre=(94.92000066mm, 76.61800018mm, 0mm), radius=0.30647032mm, height=-4.1mm)
  Cylinder2 = cylinder(axis=Z, base_centre=(81.41999972mm, 76.61800018mm, 0mm), radius=0.29999813mm, height=-4.2mm)
  Box1 [FR4_epoxy] = box(corner=(130mm, 45mm, -0.1mm), size=(-70mm, 65mm, -1.5mm))
  Box1.subtract(Cylinder1, Cylinder2)
  Box2 [air] = box(corner=(30mm, 140mm, -150mm), size=(130mm, -130mm, 300mm))
  Copper [copper] = imported_body()
  LP1 = polyline(z=0.1mm, xy in mm: (76.6700016, 77.96800002) (79.97000008, 77.96800002) (79.97000008, 77.31799878) (76.6700016, 77.31799878), closed, covered)
boundaries and excitations:
  Rad1: Radiation Objects=Box2
  1: Lumped Port Faces=LP1.face LumpedPortType=Modal Modes{Mode1{IntLine{(78.32000084, 77.31799878, 0.1) -> (78.32000084, 77.96800002, 0.1)} CharImp=Zpi}} Impedance=50ohm
setups:
  Setup1: HfssDrivenAuto AutoSolverSetting=Balanced Type=Interpolating
    sweep Sweep: 10MHz to 30MHz step 10kHz;
source amplitudes:
  1:1: 1V 0deg
reports:
  Z Parameter Plot 1: re(Z(1,1)), im(Z(1,1)) vs Freq on Setup1 : Sweep; markers m1 at 13.56MHz
