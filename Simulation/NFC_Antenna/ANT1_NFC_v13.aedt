# Ansys Electronics Desktop project, version 2023.2
materials:
  vacuum: permittivity=1
  copper: permeability=0.999991 conductivity=58000000
  FR4_epoxy: permittivity=4.4 dielectric_loss_tangent=0.02
  air: permittivity=1.0006 permeability=1.0000004

design HFSSDesign1 (HFSS, HFSS Terminal Network, model units mm)
geometry:
  Cylinder1 = cylinder(axis=Z, base_centre=(88.8080012mm, 86.5640001mm, 0mm), radius=0.29999813mm, height=-2.6mm)
  Cylinder2 = cylinder(axis=Z, base_centre=(72.80800018mm, 85.5640021mm, 0mm), radius=0.29999813mm, height=-2.6mm)
  Box1 [FR4_epoxy] = box(corner=(125mm, 55mm, -0.1mm), size=(-75mm, 65mm, -1.5mm))
  Box1.subtract(Cylinder1, Cylinder2)
  Box2 [air] = box(corner=(20mm, 150mm, -150mm), size=(140mm, -130mm, 300mm))
  Copper [copper] = imported_body()
  LP1 = polyline(z=0.1mm, xy in mm: (71.35800054, 86.2640007) (68.05800206, 86.2640007) (68.05800206, 86.91400194) (71.35800054, 86.91400194), closed, covered)
boundaries and excitations:
  Rad1: Radiation Objects=Box2
  1: Lumped Port Faces=LP1.face LumpedPortType=Modal Modes{Mode1{IntLine{(69.7080013, 86.91400194, 0.1) -> (69.7080013, 86.2640007, 0.1)} CharImp=Zpi}} Impedance=50ohm
setups:
  Setup1: HfssDrivenAuto AutoSolverSetting=Balanced Type=Interpolating
    sweep Sweep: 10MHz to 30MHz step 10kHz;
source amplitudes:
  1:1: 1V 0deg
field plots:
  Mag_E1: E Field in Box2 on Setup1 : LastAdaptive at Freq=0.02GHz Phase=0deg
  Mag_H1: H Field in Box2 on Setup1 : LastAdaptive at Freq=0.02GHz Phase=0deg
reports:
  Z Parameter Plot 1: re(Z(1,1)), im(Z(1,1)) vs Freq on Setup1 : Sweep; markers m1 at 13.56MHz
